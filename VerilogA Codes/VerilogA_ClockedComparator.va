// VerilogA for ADC_Ideal_4bit_FlashADC, VerilogA_ClockedComparator, veriloga

`include "constants.vams"
`include "disciplines.vams"

module VerilogA_ClockedComparator(dout,vref,vin,clk);

parameter real clk_th=0.9;
parameter real delay = 0;
parameter real ttime = 1p;

input vin,vref,clk;
output dout;

electrical dout,vref,vin,clk;
real d_result;

analog begin

	@(cross(V(clk) - clk_th, -1)) begin
		if(V(vin) > V(vref)) begin
			d_result = 1;
		end
		else begin
			d_result = 0;
		end
	end

	@(cross(V(clk) - clk_th, +1)) begin
		d_result = 0;
	end

	V(dout) <+ transition(d_result,delay,ttime);
end

endmodule
